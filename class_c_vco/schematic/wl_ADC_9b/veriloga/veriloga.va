// VerilogA for gz_VerilogA_lib, gz_ADC_6B, veriloga

`include "constants.vams"
`include "disciplines.vams"

module gz_ADC_8B(VIN,DOUTP);

input VIN;
output [8:0] DOUTP;
electrical VIN;
electrical [8:0] DOUTP;

parameter real voltage_high = 1;
parameter real voltage_low = 0;
parameter real vref_1b = 1;

	integer vin, do8,do7,do6,do5,do4,do3,do2,do1,do0;
	integer do8n, do7n, do6n, do5n, do4n, do3n, do2n, do1n, do0n;

	analog begin

		vin = (V(VIN) > (floor(V(VIN)/vref_1b) + vref_1b/2))? ceil(V(VIN)/vref_1b): floor(V(VIN)/vref_1b);
		do8 = (vin>>8)%2;
		do7 = (vin>>7)%2;
		do6 = (vin>>6)%2;
		do5 = (vin>>5)%2;
		do4 = (vin>>4)%2;
		do3 = (vin>>3)%2;
		do2 = (vin>>2)%2;
		do1 = (vin>>1)%2;
		do0 = (vin>>0)%2;

		do7n = ~do7;
		do6n = ~do6;
		do5n = ~do5;
		do4n = ~do4;
		do3n = ~do3;
		do2n = ~do2;
		do1n = ~do1;
		do0n = ~do0;

		V(DOUTP[8]) <+ transition(do8*voltage_high,10p,10p,10p);
		V(DOUTP[7]) <+ transition(do7*voltage_high,10p,10p,10p);
		V(DOUTP[6]) <+ transition(do6*voltage_high,10p,10p,10p);
		V(DOUTP[5]) <+ transition(do5*voltage_high,10p,10p,10p);
		V(DOUTP[4]) <+ transition(do4*voltage_high,10p,10p,10p);
		V(DOUTP[3]) <+ transition(do3*voltage_high,10p,10p,10p);
		V(DOUTP[2]) <+ transition(do2*voltage_high,10p,10p,10p);
		V(DOUTP[1]) <+ transition(do1*voltage_high,10p,10p,10p);
		V(DOUTP[0]) <+ transition(do0*voltage_high,10p,10p,10p);
;

	end

endmodule
